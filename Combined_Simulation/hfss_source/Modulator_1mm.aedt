# Ansys Electronics Desktop project, version 2023.1
materials:
  vacuum: permittivity=1
  LINbO3: permittivity=1 permeability=1
  aluminum: permeability=1.000021 conductivity=38000000
  silicon: permittivity=11.9
  silicon_dioxide: permittivity=4
  air: permittivity=1.0006 permeability=1.0000004
surface materials:
  Steel-oxidised-surface

design 1mm (HFSS, HFSS Modal Network, model units mm)
variables:
  d_si = 675um
  d_sioup = 0.8um
  d_ln = 0.4um
  d_lnbd = 0.2um
  d_au = 900nm
  d_siodw = 4.7um
  w_sig = 11um
  gap = 5um
  ly = 1000um
  LNBDSW = 1.4um
  theta1 = 60deg
  w_au = 130um
  w_sig2 = 45um
  gap2 = 25um
  l_taper = 30um
  r_bend = 100um
  l_tanzhen = 500um
  l_all = ly+l_tanzhen*2
  l_shouzhai = l_taper/2+30um
  x_z = 15um
  w_s = 100um
  w_t = 0.4um
  w_t1 = 0.2um
  r2 = 40um
  l = w_au*2+gap*2+w_sig+l_shouzhai*2+2*l_taper
  LNBDXW = d_lnbd/tan(theta1)*2+LNBDSW
  w_t2 = 0.5*(gap-LNBDXW-w_t*2-w_t1*2)
  sioxw = gap-w_t2*2
  siosw = sioxw-d_sioup/tan(theta1)*2
geometry:
  coordinate_system RelativeCS1 = origin=(0mm, (l-w_sig-gap*2-w_au*2)/2, d_si+d_siodw+d_ln+d_au) x=(1mm, 0mm, 0mm) y=(0mm, 1mm, 0mm)
  Box1 [aluminum] = box(corner=(0mm, (l-w_sig-gap*2-w_au*2)/2+r2, d_si+d_siodw+d_ln), size=(ly, w_au-r2, d_au))
  Box1.duplicate_along_line(step=(0mm, w_au-r2+w_sig+gap*2, 0mm), total=2, attached)
  Polyline1 = polyline((0mm, (l-w_sig-gap*2-w_au*2)/2, d_si+d_siodw+d_ln+d_au) (0mm, (l-w_sig-gap*2-w_au*2)/2+w_au, d_si+d_siodw+d_ln+d_au))
  Polyline1.sweep_around_axis(axis=Z, angle=90deg) in RelativeCS1
  Polyline18 = polyline((0mm, (l-w_sig-gap*2-w_au*2)/2+r2, d_si+d_siodw+d_ln+d_au) (0mm, (l-w_sig-gap*2-w_au*2)/2, d_si+d_siodw+d_ln+d_au))
  Polyline18.sweep_around_axis(axis=Z, angle=90deg) in RelativeCS1
  Polyline1.subtract(Polyline18)
  Polyline16 = polyline(z=0mm, xy: (-w_au, 0mm) (-w_au+(w_sig2-w_sig)/2+gap2-gap, -l_shouzhai) (-w_au+(w_sig2-w_sig)/2+gap2-gap, -l_taper-l_shouzhai) (ly+w_au*2+gap*2+w_sig+ w_s, -l_taper-l_shouzhai) (ly+w_au*2+gap*2+w_sig+ w_s, 0mm) (-w_au, 0mm), covered) in RelativeCS1
  Polyline20 = polyline(z=0mm, xy: (-w_au+(w_au-r2), 0mm) (-w_au+(w_sig2-w_sig)/2+gap2-gap+(w_au-r2), -l_shouzhai) (-w_au+(w_sig2-w_sig)/2+gap2-gap+(w_au-r2), -l_taper-l_shouzhai) (ly+w_au*2+gap*2+w_sig+ w_s, -l_taper-l_shouzhai) (ly+w_au*2+gap*2+w_sig+ w_s, 0mm) (-w_au+(w_au-r2), 0mm), covered) in RelativeCS1
  Polyline16.subtract(Polyline20)
  Polyline1.unite(Polyline16)
  Polyline1.thicken(-d_au)
  Polyline1_1 = Polyline1.duplicate_around_axis(axis=Z, angle=180deg, total=2) in RelativeCS1
  Polyline1_1.move(ly, w_au*2+gap*2+w_sig, 0mm) in RelativeCS1
  Polyline4 = polyline((0mm, (l-w_sig-gap*2-w_au*2)/2+w_au-r2+gap+w_sig+gap+w_au, d_si+d_siodw+d_ln+d_au) (0mm, (l-w_sig-gap*2-w_au*2)/2+w_au+gap+w_sig+gap, d_si+d_siodw+d_ln+d_au))
  Polyline4.sweep_around_axis(axis=Z, angle=90deg) in RelativeCS1
  Polyline13 = polyline(z=0mm, xy: (-w_au-w_sig-gap*2, 0mm) (-w_au-w_sig-gap-(w_sig2-w_sig)/2-gap2, -l_shouzhai) (-w_au-w_sig-gap-(w_sig2-w_sig)/2-gap2, -l_taper-l_shouzhai) (-w_au-w_sig-gap-(w_sig2-w_sig)/2-gap2-(w_au-r2), -l_taper-l_shouzhai) (-w_au-w_sig-gap-(w_sig2-w_sig)/2-gap2-(w_au-r2), -l_shouzhai) (-w_au-w_sig-gap*2-(w_au-r2), 0mm) (-w_au-w_sig-gap*2, 0mm), covered) in RelativeCS1
  Polyline4.unite(Polyline13)
  Polyline4.thicken(d_au)
  Polyline4_1 = Polyline4.duplicate_around_axis(axis=Z, angle=180deg, total=2) in RelativeCS1
  Polyline4_1.move(ly, w_au*2+gap*2+w_sig, 0mm) in RelativeCS1
  Box1.unite(Polyline1, Polyline4, Polyline1_1, Polyline4_1)
  Box2 [aluminum] = box(corner=(0mm, (l-w_sig-gap*2-w_au*2)/2+gap+w_au, d_si+d_siodw+d_ln), size=(ly, w_sig, d_au))
  Polyline12 = polyline((-w_au-w_sig-gap, 0mm, 0mm) (-w_au-gap, 0mm, 0mm)) in RelativeCS1
  Polyline17 = polyline(z=0mm, xy: (-w_au-w_sig-gap, 0mm) (-w_au-w_sig-gap-(w_sig2-w_sig)/2, -l_shouzhai) (-w_au-w_sig-gap-(w_sig2-w_sig)/2, -l_shouzhai-l_taper) (-w_au-w_sig-gap-(w_sig2-w_sig)/2+w_sig2, -l_taper-l_shouzhai) (-w_au-w_sig-gap-(w_sig2-w_sig)/2+w_sig2, -l_shouzhai) (-w_au-gap, 0mm)) in RelativeCS1
  Polyline12.unite(Polyline17)
  Polyline12.cover_lines()
  Polyline3 = polyline((0mm, (l-w_sig-gap*2-w_au*2)/2+w_au+gap+w_sig, d_si+d_siodw+d_ln+d_au) (0mm, (l-w_sig-gap*2-w_au*2)/2+w_au+gap, d_si+d_siodw+d_ln+d_au))
  Polyline3.sweep_around_axis(axis=Z, angle=90deg) in RelativeCS1
  Polyline12.unite(Polyline3)
  Polyline12_1 = Polyline12.duplicate_around_axis(axis=Z, angle=180deg, total=2) in RelativeCS1
  Polyline12.thicken(d_au)
  Polyline12_1.move(ly, w_au*2+gap*2+w_sig, 0mm) in RelativeCS1
  Polyline12_1.thicken(d_au)
  Box2.unite(Polyline12, Polyline12_1)
  si [silicon] = box(corner=(-l_tanzhen, 0mm, 0mm), size=(l_all, l, d_si))
  LNBD1 [LINbO3] = polyline((0mm, (l-w_sig-gap*2-w_au*2)/2+w_au+gap/2, d_si+d_siodw+d_ln+d_lnbd/2) (ly, (l-w_sig-gap*2-w_au*2)/2+w_au+gap/2, d_si+d_siodw+d_ln+d_lnbd/2), section isosceles trapezoid width=LNBDXW top_width=LNBDSW height=d_lnbd)
  LNBD1.duplicate_along_line(step=(0mm, w_sig+gap, 0mm), total=2, attached)
  SIOdw [silicon_dioxide] = object_from(si.face(+z))
  SIOdw.thicken(d_siodw)
  sioup [silicon_dioxide] = polyline((0mm, (l-w_sig-gap*2-w_au*2)/2+w_au+gap/2, d_si+d_siodw+d_ln+d_sioup/2) (ly, (l-w_sig-gap*2-w_au*2)/2+w_au+gap/2, d_si+d_siodw+d_ln+d_sioup/2), section isosceles trapezoid width=sioxw top_width=siosw height=d_sioup)
  sioup.duplicate_along_line(step=(0mm, w_sig+gap, 0mm), total=2, attached)
  LNBD1_1 = LNBD1.copy()
  sioup.subtract(LNBD1_1)
  LN [LINbO3] = object_from(SIOdw.face(at (0.5, 0.2155, 0.6797)))
  LN.thicken(d_ln)
  Region [vacuum] = region(percentage_offset: +X=0, -X=0, +Y=0, -Y=0, +Z=30, -Z=0)
  Rectangle1 = rectangle(corner=(-w_au+(w_sig2-w_sig)/2+gap2-gap-gap2-w_sig2/2-(2*gap2+w_sig2)*2/2, -l_taper-l_shouzhai, -160um), z_size=(2*gap2+w_sig2)*2, x_size=320um) in RelativeCS1
  Rectangle2 = rectangle(corner=(ly-(-w_au-gap+(w_sig2-w_sig)/2 )+w_sig2/2-(2*gap2+w_sig2)*2/2, w_au*2+gap*2+w_sig+l_taper+l_shouzhai, -160um), z_size=(2*gap2+w_sig2)*2, x_size=320um) in RelativeCS1
boundaries and excitations:
  Rad1: Radiation Faces=Region.face(+z, -y, -x, +y, +x)
  PerfE1: Radiation Faces=Region.face(-z)
  1: Wave Port Faces=Rectangle1.face WavePortType=Modal NumModes=1 Modes{Mode1{CharImp=Zpi RenormImp=50ohm}}
  2: Wave Port Faces=Rectangle2.face WavePortType=Modal NumModes=1 Modes{Mode1{CharImp=Zpi RenormImp=50ohm}}
setups:
  Setup1: HfssDriven Frequency=40GHz MaxDeltaS=0.02 MaximumPasses=20 MinimumPasses=1 MinimumConvergedPasses=1 PercentRefinement=30 BasisOrder=1 PortAccuracy=2 DrivenSolverType="Direct Solver"
    sweep Sweep: 39GHz to 60GHz, 401 points; Type=Interpolating SaveFields InterpTolerance=0.5 InterpMaxSolns=250 InterpUsePortImped=false PassivityErrorTolerance=0.0001
source amplitudes:
  1:1: 1W 0deg
  2:1: 0W 0deg
